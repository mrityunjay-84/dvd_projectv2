* Leakage = -i(vdd) - i(v<input>) for every input held at VDD.
* 8-bit parity checker, corner 0, inputs all 0
.options gmin=1e-18 abstol=1e-18 reltol=1e-6 vntol=1e-9
.temp 13.04415201
.model nch nmos  level = 54

+version = 4.0             binunit = 1               paramchk= 1               mobmod  = 0
+capmod  = 2               igcmod  = 1               igbmod  = 1               geomod  = 1
+diomod  = 1               rdsmod  = 0               rbodymod= 1               rgatemod= 1
+permod  = 1               acnqsmod= 0               trnqsmod= 0

+tnom    = 27              toxe    = 1.007985694e-09       toxp    = 8e-010          toxm    = 1.05e-009
+dtox    = 2.5e-010        epsrox  = 3.9             wint    = 5e-009          lint    = 2e-009
+ll      = 0               wl      = 0               lln     = 1               wln     = 1
+lw      = 0               ww      = 0               lwn     = 1               wwn     = 1
+lwl     = 0               wwl     = 0               xpart   = 0               toxref  = 1.05e-009
+xl	   = -9e-9

+vth0    = 0.5118221226         k1      = 0.4             k2      = 0               k3      = 0
+k3b     = 0               w0      = 2.5e-006        dvt0    = 1               dvt1    = 2
+dvt2    = 0               dvt0w   = 0               dvt1w   = 0               dvt2w   = 0
+dsub    = 0.1             minv    = 0.05            voffl   = 0               dvtp0   = 1e-011
+dvtp1   = 0.1             lpe0    = 0               lpeb    = 0               xj      = 7.079706203e-09
+ngate   = 1e+023          ndep    = 5.717207766e+18        nsd     = 2e+020          phin    = 0
+cdsc    = 0               cdscb   = 0               cdscd   = 0               cit     = 0
+voff    = -0.13           nfactor = 2.3             eta0    = 0.004           etab    = 0
+vfb     = -0.55           u0      = 0.03911558593            ua      = 6e-010          ub      = 1.2e-018
+uc      = 0               vsat    = 250000          a0      = 1               ags     = 0
+a1      = 0               a2      = 1               b0      = 0               b1      = 0
+keta    = 0.04            dwg     = 0               dwb     = 0               pclm    = 0.02
+pdiblc1 = 0.001           pdiblc2 = 0.001           pdiblcb = -0.005          drout   = 0.5
+pvag    = 1e-020          delta   = 0.01            pscbe1  = 8.14e+008       pscbe2  = 1e-007
+fprout  = 0.2             pdits   = 0.01            pditsd  = 0.23            pditsl  = 2300000
+rsh     = 5               rdsw    = 145             rsw     = 75              rdw     = 75
+rdswmin = 0               rdwmin  = 0               rswmin  = 0               prwg    = 0
+prwb    = 0               wr      = 1               alpha0  = 0.074           alpha1  = 0.005
+beta0   = 30              agidl   = 0.0002          bgidl   = 2.1e+009        cgidl   = 0.0002
+egidl   = 0.8             aigbacc = 0.012           bigbacc = 0.0028          cigbacc = 0.002
+nigbacc = 1               aigbinv = 0.014           bigbinv = 0.004           cigbinv = 0.004
+eigbinv = 1.1             nigbinv = 3               aigc    = 0.0213          bigc    = 0.0025889
+cigc    = 0.002           aigsd   = 0.0213          bigsd   = 0.0025889       cigsd   = 0.002
+nigc    = 1               poxedge = 1               pigcd   = 1               ntox    = 1
+xrcrg1  = 12              xrcrg2  = 5

+cgso    = 6.5e-011        cgdo    = 6.5e-011        cgbo    = 2.56e-011       cgdl    = 2.653e-010
+cgsl    = 2.653e-010      ckappas = 0.03            ckappad = 0.03            acde    = 1
+moin    = 15              noff    = 0.9             voffcv  = 0.02

+kt1     = -0.11           kt1l    = 0               kt2     = 0.022           ute     = -1.5
+ua1     = 4.31e-009       ub1     = 7.61e-018       uc1     = -5.6e-011       prt     = 0
+at      = 33000

+fnoimod = 1               tnoimod = 0

+jss     = 0.0001          jsws    = 1e-011          jswgs   = 1e-010          njs     = 1
+ijthsfwd= 0.01            ijthsrev= 0.001           bvs     = 10              xjbvs   = 1
+jsd     = 0.0001          jswd    = 1e-011          jswgd   = 1e-010          njd     = 1
+ijthdfwd= 0.01            ijthdrev= 0.001           bvd     = 10              xjbvd   = 1
+pbs     = 1               cjs     = 0.0005          mjs     = 0.5             pbsws   = 1
+cjsws   = 5e-010          mjsws   = 0.33            pbswgs  = 1               cjswgs  = 3e-010
+mjswgs  = 0.33            pbd     = 1               cjd     = 0.0005          mjd     = 0.5
+pbswd   = 1               cjswd   = 5e-010          mjswd   = 0.33            pbswgd  = 1
+cjswgd  = 5e-010          mjswgd  = 0.33            tpb     = 0.005           tcj     = 0.001
+tpbsw   = 0.005           tcjsw   = 0.001           tpbswg  = 0.005           tcjswg  = 0.001
+xtis    = 3               xtid    = 3

+dmcg    = 0               dmci    = 0               dmdg    = 0               dmcgt   = 0
+dwj     = 0               xgw     = 0               xgl     = 0

+rshg    = 0.4             gbmin   = 1e-010          rbpb    = 5               rbpd    = 15
+rbps    = 15              rbdb    = 15              rbsb    = 15              ngcon   = 1
.model pch pmos  level = 54

+version = 4.0             binunit = 1               paramchk= 1               mobmod  = 0
+capmod  = 2               igcmod  = 1               igbmod  = 1               geomod  = 1
+diomod  = 1               rdsmod  = 0               rbodymod= 1               rgatemod= 1
+permod  = 1               acnqsmod= 0               trnqsmod= 0

+tnom    = 27              toxe    = 1.202974258e-09        toxp    = 8e-010          toxm    = 1.1e-009
+dtox    = 3e-010          epsrox  = 3.9             wint    = 5e-009          lint    = 2e-009
+ll      = 0               wl      = 0               lln     = 1               wln     = 1
+lw      = 0               ww      = 0               lwn     = 1               wwn     = 1
+lwl     = 0               wwl     = 0               xpart   = 0               toxref  = 1.1e-009
+xl	   = -9e-9

+vth0    = -0.4654582876         k1      = 0.4             k2      = -0.01           k3      = 0
+k3b     = 0               w0      = 2.5e-006        dvt0    = 1               dvt1    = 2
+dvt2    = -0.032          dvt0w   = 0               dvt1w   = 0               dvt2w   = 0
+dsub    = 0.1             minv    = 0.05            voffl   = 0               dvtp0   = 1e-011
+dvtp1   = 0.05            lpe0    = 0               lpeb    = 0               xj      = 7.600606647e-09
+ngate   = 1e+023          ndep    = 4.23956733e+18        nsd     = 2e+020          phin    = 0
+cdsc    = 0               cdscb   = 0               cdscd   = 0               cit     = 0
+voff    = -0.126          nfactor = 2.1             eta0    = 0.0038          etab    = 0
+vfb     = 0.55            u0      = 0.009697079489          ua      = 2e-009          ub      = 5e-019
+uc      = 0               vsat    = 210000          a0      = 1               ags     = 1e-020
+a1      = 0               a2      = 1               b0      = 0               b1      = 0
+keta    = -0.047          dwg     = 0               dwb     = 0               pclm    = 0.12
+pdiblc1 = 0.001           pdiblc2 = 0.001           pdiblcb = 3.4e-008        drout   = 0.56
+pvag    = 1e-020          delta   = 0.01            pscbe1  = 8.14e+008       pscbe2  = 9.58e-007
+fprout  = 0.2             pdits   = 0.08            pditsd  = 0.23            pditsl  = 2300000
+rsh     = 5               rdsw    = 145             rsw     = 72.5            rdw     = 72.5
+rdswmin = 0               rdwmin  = 0               rswmin  = 0               prwg    = 0
+prwb    = 0               wr      = 1               alpha0  = 0.074           alpha1  = 0.005
+beta0   = 30              agidl   = 0.0002          bgidl   = 2.1e+009        cgidl   = 0.0002
+egidl   = 0.8             aigbacc = 0.012           bigbacc = 0.0028          cigbacc = 0.002
+nigbacc = 1               aigbinv = 0.014           bigbinv = 0.004           cigbinv = 0.004
+eigbinv = 1.1             nigbinv = 3               aigc    = 0.0213          bigc    = 0.0025889
+cigc    = 0.002           aigsd   = 0.0213          bigsd   = 0.0025889       cigsd   = 0.002
+nigc    = 1               poxedge = 1               pigcd   = 1               ntox    = 1
+xrcrg1  = 12              xrcrg2  = 5

+cgso    = 6.5e-011        cgdo    = 6.5e-011        cgbo    = 2.56e-011       cgdl    = 2.653e-010
+cgsl    = 2.653e-010      ckappas = 0.03            ckappad = 0.03            acde    = 1
+moin    = 15              noff    = 0.9             voffcv  = 0.02

+kt1     = -0.11           kt1l    = 0               kt2     = 0.022           ute     = -1.5
+ua1     = 4.31e-009       ub1     = 7.61e-018       uc1     = -5.6e-011       prt     = 0
+at      = 33000

+fnoimod = 1               tnoimod = 0

+jss     = 0.0001          jsws    = 1e-011          jswgs   = 1e-010          njs     = 1
+ijthsfwd= 0.01            ijthsrev= 0.001           bvs     = 10              xjbvs   = 1
+jsd     = 0.0001          jswd    = 1e-011          jswgd   = 1e-010          njd     = 1
+ijthdfwd= 0.01            ijthdrev= 0.001           bvd     = 10              xjbvd   = 1
+pbs     = 1               cjs     = 0.0005          mjs     = 0.5             pbsws   = 1
+cjsws   = 5e-010          mjsws   = 0.33            pbswgs  = 1               cjswgs  = 3e-010
+mjswgs  = 0.33            pbd     = 1               cjd     = 0.0005          mjd     = 0.5
+pbswd   = 1               cjswd   = 5e-010          mjswd   = 0.33            pbswgd  = 1
+cjswgd  = 5e-010          mjswgd  = 0.33            tpb     = 0.005           tcj     = 0.001
+tpbsw   = 0.005           tcjsw   = 0.001           tpbswg  = 0.005           tcjswg  = 0.001
+xtis    = 3               xtid    = 3

+dmcg    = 0               dmci    = 0               dmdg    = 0               dmcgt   = 0
+dwj     = 0               xgw     = 0               xgl     = 0

+rshg    = 0.4             gbmin   = 1e-010          rbpb    = 5               rbpd    = 15
+rbps    = 15              rbdb    = 15              rbsb    = 15              ngcon   = 1
MPAx0g1 x0n1 i0 vdd vdd pch W=1.32e-07 L=2.2e-08 rgatemod=0 rbodymod=0 AD=5.808e-15 AS=5.808e-15 PD=3.52e-07 PS=3.52e-07
MPBx0g1 x0n1 i1 vdd vdd pch W=1.32e-07 L=2.2e-08 rgatemod=0 rbodymod=0 AD=5.808e-15 AS=5.808e-15 PD=3.52e-07 PS=3.52e-07
MNBx0g1 x0n1 i1 x0g1x 0 nch W=6.6e-08 L=2.2e-08 rgatemod=0 rbodymod=0 AD=2.904e-15 AS=2.904e-15 PD=2.2e-07 PS=2.2e-07
MNAx0g1 x0g1x i0 0 0 nch W=6.6e-08 L=2.2e-08 rgatemod=0 rbodymod=0 AD=2.904e-15 AS=2.904e-15 PD=2.2e-07 PS=2.2e-07
MPAx0g2 x0n2 i0 vdd vdd pch W=1.32e-07 L=2.2e-08 rgatemod=0 rbodymod=0 AD=5.808e-15 AS=5.808e-15 PD=3.52e-07 PS=3.52e-07
MPBx0g2 x0n2 x0n1 vdd vdd pch W=1.32e-07 L=2.2e-08 rgatemod=0 rbodymod=0 AD=5.808e-15 AS=5.808e-15 PD=3.52e-07 PS=3.52e-07
MNBx0g2 x0n2 x0n1 x0g2x 0 nch W=6.6e-08 L=2.2e-08 rgatemod=0 rbodymod=0 AD=2.904e-15 AS=2.904e-15 PD=2.2e-07 PS=2.2e-07
MNAx0g2 x0g2x i0 0 0 nch W=6.6e-08 L=2.2e-08 rgatemod=0 rbodymod=0 AD=2.904e-15 AS=2.904e-15 PD=2.2e-07 PS=2.2e-07
MPAx0g3 x0n3 i1 vdd vdd pch W=1.32e-07 L=2.2e-08 rgatemod=0 rbodymod=0 AD=5.808e-15 AS=5.808e-15 PD=3.52e-07 PS=3.52e-07
MPBx0g3 x0n3 x0n1 vdd vdd pch W=1.32e-07 L=2.2e-08 rgatemod=0 rbodymod=0 AD=5.808e-15 AS=5.808e-15 PD=3.52e-07 PS=3.52e-07
MNBx0g3 x0n3 x0n1 x0g3x 0 nch W=6.6e-08 L=2.2e-08 rgatemod=0 rbodymod=0 AD=2.904e-15 AS=2.904e-15 PD=2.2e-07 PS=2.2e-07
MNAx0g3 x0g3x i1 0 0 nch W=6.6e-08 L=2.2e-08 rgatemod=0 rbodymod=0 AD=2.904e-15 AS=2.904e-15 PD=2.2e-07 PS=2.2e-07
MPAx0g4 p0 x0n2 vdd vdd pch W=1.32e-07 L=2.2e-08 rgatemod=0 rbodymod=0 AD=5.808e-15 AS=5.808e-15 PD=3.52e-07 PS=3.52e-07
MPBx0g4 p0 x0n3 vdd vdd pch W=1.32e-07 L=2.2e-08 rgatemod=0 rbodymod=0 AD=5.808e-15 AS=5.808e-15 PD=3.52e-07 PS=3.52e-07
MNBx0g4 p0 x0n3 x0g4x 0 nch W=6.6e-08 L=2.2e-08 rgatemod=0 rbodymod=0 AD=2.904e-15 AS=2.904e-15 PD=2.2e-07 PS=2.2e-07
MNAx0g4 x0g4x x0n2 0 0 nch W=6.6e-08 L=2.2e-08 rgatemod=0 rbodymod=0 AD=2.904e-15 AS=2.904e-15 PD=2.2e-07 PS=2.2e-07
MPAx1g1 x1n1 i2 vdd vdd pch W=1.32e-07 L=2.2e-08 rgatemod=0 rbodymod=0 AD=5.808e-15 AS=5.808e-15 PD=3.52e-07 PS=3.52e-07
MPBx1g1 x1n1 i3 vdd vdd pch W=1.32e-07 L=2.2e-08 rgatemod=0 rbodymod=0 AD=5.808e-15 AS=5.808e-15 PD=3.52e-07 PS=3.52e-07
MNBx1g1 x1n1 i3 x1g1x 0 nch W=6.6e-08 L=2.2e-08 rgatemod=0 rbodymod=0 AD=2.904e-15 AS=2.904e-15 PD=2.2e-07 PS=2.2e-07
MNAx1g1 x1g1x i2 0 0 nch W=6.6e-08 L=2.2e-08 rgatemod=0 rbodymod=0 AD=2.904e-15 AS=2.904e-15 PD=2.2e-07 PS=2.2e-07
MPAx1g2 x1n2 i2 vdd vdd pch W=1.32e-07 L=2.2e-08 rgatemod=0 rbodymod=0 AD=5.808e-15 AS=5.808e-15 PD=3.52e-07 PS=3.52e-07
MPBx1g2 x1n2 x1n1 vdd vdd pch W=1.32e-07 L=2.2e-08 rgatemod=0 rbodymod=0 AD=5.808e-15 AS=5.808e-15 PD=3.52e-07 PS=3.52e-07
MNBx1g2 x1n2 x1n1 x1g2x 0 nch W=6.6e-08 L=2.2e-08 rgatemod=0 rbodymod=0 AD=2.904e-15 AS=2.904e-15 PD=2.2e-07 PS=2.2e-07
MNAx1g2 x1g2x i2 0 0 nch W=6.6e-08 L=2.2e-08 rgatemod=0 rbodymod=0 AD=2.904e-15 AS=2.904e-15 PD=2.2e-07 PS=2.2e-07
MPAx1g3 x1n3 i3 vdd vdd pch W=1.32e-07 L=2.2e-08 rgatemod=0 rbodymod=0 AD=5.808e-15 AS=5.808e-15 PD=3.52e-07 PS=3.52e-07
MPBx1g3 x1n3 x1n1 vdd vdd pch W=1.32e-07 L=2.2e-08 rgatemod=0 rbodymod=0 AD=5.808e-15 AS=5.808e-15 PD=3.52e-07 PS=3.52e-07
MNBx1g3 x1n3 x1n1 x1g3x 0 nch W=6.6e-08 L=2.2e-08 rgatemod=0 rbodymod=0 AD=2.904e-15 AS=2.904e-15 PD=2.2e-07 PS=2.2e-07
MNAx1g3 x1g3x i3 0 0 nch W=6.6e-08 L=2.2e-08 rgatemod=0 rbodymod=0 AD=2.904e-15 AS=2.904e-15 PD=2.2e-07 PS=2.2e-07
MPAx1g4 p1 x1n2 vdd vdd pch W=1.32e-07 L=2.2e-08 rgatemod=0 rbodymod=0 AD=5.808e-15 AS=5.808e-15 PD=3.52e-07 PS=3.52e-07
MPBx1g4 p1 x1n3 vdd vdd pch W=1.32e-07 L=2.2e-08 rgatemod=0 rbodymod=0 AD=5.808e-15 AS=5.808e-15 PD=3.52e-07 PS=3.52e-07
MNBx1g4 p1 x1n3 x1g4x 0 nch W=6.6e-08 L=2.2e-08 rgatemod=0 rbodymod=0 AD=2.904e-15 AS=2.904e-15 PD=2.2e-07 PS=2.2e-07
MNAx1g4 x1g4x x1n2 0 0 nch W=6.6e-08 L=2.2e-08 rgatemod=0 rbodymod=0 AD=2.904e-15 AS=2.904e-15 PD=2.2e-07 PS=2.2e-07
MPAx2g1 x2n1 i4 vdd vdd pch W=1.32e-07 L=2.2e-08 rgatemod=0 rbodymod=0 AD=5.808e-15 AS=5.808e-15 PD=3.52e-07 PS=3.52e-07
MPBx2g1 x2n1 i5 vdd vdd pch W=1.32e-07 L=2.2e-08 rgatemod=0 rbodymod=0 AD=5.808e-15 AS=5.808e-15 PD=3.52e-07 PS=3.52e-07
MNBx2g1 x2n1 i5 x2g1x 0 nch W=6.6e-08 L=2.2e-08 rgatemod=0 rbodymod=0 AD=2.904e-15 AS=2.904e-15 PD=2.2e-07 PS=2.2e-07
MNAx2g1 x2g1x i4 0 0 nch W=6.6e-08 L=2.2e-08 rgatemod=0 rbodymod=0 AD=2.904e-15 AS=2.904e-15 PD=2.2e-07 PS=2.2e-07
MPAx2g2 x2n2 i4 vdd vdd pch W=1.32e-07 L=2.2e-08 rgatemod=0 rbodymod=0 AD=5.808e-15 AS=5.808e-15 PD=3.52e-07 PS=3.52e-07
MPBx2g2 x2n2 x2n1 vdd vdd pch W=1.32e-07 L=2.2e-08 rgatemod=0 rbodymod=0 AD=5.808e-15 AS=5.808e-15 PD=3.52e-07 PS=3.52e-07
MNBx2g2 x2n2 x2n1 x2g2x 0 nch W=6.6e-08 L=2.2e-08 rgatemod=0 rbodymod=0 AD=2.904e-15 AS=2.904e-15 PD=2.2e-07 PS=2.2e-07
MNAx2g2 x2g2x i4 0 0 nch W=6.6e-08 L=2.2e-08 rgatemod=0 rbodymod=0 AD=2.904e-15 AS=2.904e-15 PD=2.2e-07 PS=2.2e-07
MPAx2g3 x2n3 i5 vdd vdd pch W=1.32e-07 L=2.2e-08 rgatemod=0 rbodymod=0 AD=5.808e-15 AS=5.808e-15 PD=3.52e-07 PS=3.52e-07
MPBx2g3 x2n3 x2n1 vdd vdd pch W=1.32e-07 L=2.2e-08 rgatemod=0 rbodymod=0 AD=5.808e-15 AS=5.808e-15 PD=3.52e-07 PS=3.52e-07
MNBx2g3 x2n3 x2n1 x2g3x 0 nch W=6.6e-08 L=2.2e-08 rgatemod=0 rbodymod=0 AD=2.904e-15 AS=2.904e-15 PD=2.2e-07 PS=2.2e-07
MNAx2g3 x2g3x i5 0 0 nch W=6.6e-08 L=2.2e-08 rgatemod=0 rbodymod=0 AD=2.904e-15 AS=2.904e-15 PD=2.2e-07 PS=2.2e-07
MPAx2g4 p2 x2n2 vdd vdd pch W=1.32e-07 L=2.2e-08 rgatemod=0 rbodymod=0 AD=5.808e-15 AS=5.808e-15 PD=3.52e-07 PS=3.52e-07
MPBx2g4 p2 x2n3 vdd vdd pch W=1.32e-07 L=2.2e-08 rgatemod=0 rbodymod=0 AD=5.808e-15 AS=5.808e-15 PD=3.52e-07 PS=3.52e-07
MNBx2g4 p2 x2n3 x2g4x 0 nch W=6.6e-08 L=2.2e-08 rgatemod=0 rbodymod=0 AD=2.904e-15 AS=2.904e-15 PD=2.2e-07 PS=2.2e-07
MNAx2g4 x2g4x x2n2 0 0 nch W=6.6e-08 L=2.2e-08 rgatemod=0 rbodymod=0 AD=2.904e-15 AS=2.904e-15 PD=2.2e-07 PS=2.2e-07
MPAx3g1 x3n1 i6 vdd vdd pch W=1.32e-07 L=2.2e-08 rgatemod=0 rbodymod=0 AD=5.808e-15 AS=5.808e-15 PD=3.52e-07 PS=3.52e-07
MPBx3g1 x3n1 i7 vdd vdd pch W=1.32e-07 L=2.2e-08 rgatemod=0 rbodymod=0 AD=5.808e-15 AS=5.808e-15 PD=3.52e-07 PS=3.52e-07
MNBx3g1 x3n1 i7 x3g1x 0 nch W=6.6e-08 L=2.2e-08 rgatemod=0 rbodymod=0 AD=2.904e-15 AS=2.904e-15 PD=2.2e-07 PS=2.2e-07
MNAx3g1 x3g1x i6 0 0 nch W=6.6e-08 L=2.2e-08 rgatemod=0 rbodymod=0 AD=2.904e-15 AS=2.904e-15 PD=2.2e-07 PS=2.2e-07
MPAx3g2 x3n2 i6 vdd vdd pch W=1.32e-07 L=2.2e-08 rgatemod=0 rbodymod=0 AD=5.808e-15 AS=5.808e-15 PD=3.52e-07 PS=3.52e-07
MPBx3g2 x3n2 x3n1 vdd vdd pch W=1.32e-07 L=2.2e-08 rgatemod=0 rbodymod=0 AD=5.808e-15 AS=5.808e-15 PD=3.52e-07 PS=3.52e-07
MNBx3g2 x3n2 x3n1 x3g2x 0 nch W=6.6e-08 L=2.2e-08 rgatemod=0 rbodymod=0 AD=2.904e-15 AS=2.904e-15 PD=2.2e-07 PS=2.2e-07
MNAx3g2 x3g2x i6 0 0 nch W=6.6e-08 L=2.2e-08 rgatemod=0 rbodymod=0 AD=2.904e-15 AS=2.904e-15 PD=2.2e-07 PS=2.2e-07
MPAx3g3 x3n3 i7 vdd vdd pch W=1.32e-07 L=2.2e-08 rgatemod=0 rbodymod=0 AD=5.808e-15 AS=5.808e-15 PD=3.52e-07 PS=3.52e-07
MPBx3g3 x3n3 x3n1 vdd vdd pch W=1.32e-07 L=2.2e-08 rgatemod=0 rbodymod=0 AD=5.808e-15 AS=5.808e-15 PD=3.52e-07 PS=3.52e-07
MNBx3g3 x3n3 x3n1 x3g3x 0 nch W=6.6e-08 L=2.2e-08 rgatemod=0 rbodymod=0 AD=2.904e-15 AS=2.904e-15 PD=2.2e-07 PS=2.2e-07
MNAx3g3 x3g3x i7 0 0 nch W=6.6e-08 L=2.2e-08 rgatemod=0 rbodymod=0 AD=2.904e-15 AS=2.904e-15 PD=2.2e-07 PS=2.2e-07
MPAx3g4 p3 x3n2 vdd vdd pch W=1.32e-07 L=2.2e-08 rgatemod=0 rbodymod=0 AD=5.808e-15 AS=5.808e-15 PD=3.52e-07 PS=3.52e-07
MPBx3g4 p3 x3n3 vdd vdd pch W=1.32e-07 L=2.2e-08 rgatemod=0 rbodymod=0 AD=5.808e-15 AS=5.808e-15 PD=3.52e-07 PS=3.52e-07
MNBx3g4 p3 x3n3 x3g4x 0 nch W=6.6e-08 L=2.2e-08 rgatemod=0 rbodymod=0 AD=2.904e-15 AS=2.904e-15 PD=2.2e-07 PS=2.2e-07
MNAx3g4 x3g4x x3n2 0 0 nch W=6.6e-08 L=2.2e-08 rgatemod=0 rbodymod=0 AD=2.904e-15 AS=2.904e-15 PD=2.2e-07 PS=2.2e-07
MPAx4g1 x4n1 p0 vdd vdd pch W=1.32e-07 L=2.2e-08 rgatemod=0 rbodymod=0 AD=5.808e-15 AS=5.808e-15 PD=3.52e-07 PS=3.52e-07
MPBx4g1 x4n1 p1 vdd vdd pch W=1.32e-07 L=2.2e-08 rgatemod=0 rbodymod=0 AD=5.808e-15 AS=5.808e-15 PD=3.52e-07 PS=3.52e-07
MNBx4g1 x4n1 p1 x4g1x 0 nch W=6.6e-08 L=2.2e-08 rgatemod=0 rbodymod=0 AD=2.904e-15 AS=2.904e-15 PD=2.2e-07 PS=2.2e-07
MNAx4g1 x4g1x p0 0 0 nch W=6.6e-08 L=2.2e-08 rgatemod=0 rbodymod=0 AD=2.904e-15 AS=2.904e-15 PD=2.2e-07 PS=2.2e-07
MPAx4g2 x4n2 p0 vdd vdd pch W=1.32e-07 L=2.2e-08 rgatemod=0 rbodymod=0 AD=5.808e-15 AS=5.808e-15 PD=3.52e-07 PS=3.52e-07
MPBx4g2 x4n2 x4n1 vdd vdd pch W=1.32e-07 L=2.2e-08 rgatemod=0 rbodymod=0 AD=5.808e-15 AS=5.808e-15 PD=3.52e-07 PS=3.52e-07
MNBx4g2 x4n2 x4n1 x4g2x 0 nch W=6.6e-08 L=2.2e-08 rgatemod=0 rbodymod=0 AD=2.904e-15 AS=2.904e-15 PD=2.2e-07 PS=2.2e-07
MNAx4g2 x4g2x p0 0 0 nch W=6.6e-08 L=2.2e-08 rgatemod=0 rbodymod=0 AD=2.904e-15 AS=2.904e-15 PD=2.2e-07 PS=2.2e-07
MPAx4g3 x4n3 p1 vdd vdd pch W=1.32e-07 L=2.2e-08 rgatemod=0 rbodymod=0 AD=5.808e-15 AS=5.808e-15 PD=3.52e-07 PS=3.52e-07
MPBx4g3 x4n3 x4n1 vdd vdd pch W=1.32e-07 L=2.2e-08 rgatemod=0 rbodymod=0 AD=5.808e-15 AS=5.808e-15 PD=3.52e-07 PS=3.52e-07
MNBx4g3 x4n3 x4n1 x4g3x 0 nch W=6.6e-08 L=2.2e-08 rgatemod=0 rbodymod=0 AD=2.904e-15 AS=2.904e-15 PD=2.2e-07 PS=2.2e-07
MNAx4g3 x4g3x p1 0 0 nch W=6.6e-08 L=2.2e-08 rgatemod=0 rbodymod=0 AD=2.904e-15 AS=2.904e-15 PD=2.2e-07 PS=2.2e-07
MPAx4g4 q0 x4n2 vdd vdd pch W=1.32e-07 L=2.2e-08 rgatemod=0 rbodymod=0 AD=5.808e-15 AS=5.808e-15 PD=3.52e-07 PS=3.52e-07
MPBx4g4 q0 x4n3 vdd vdd pch W=1.32e-07 L=2.2e-08 rgatemod=0 rbodymod=0 AD=5.808e-15 AS=5.808e-15 PD=3.52e-07 PS=3.52e-07
MNBx4g4 q0 x4n3 x4g4x 0 nch W=6.6e-08 L=2.2e-08 rgatemod=0 rbodymod=0 AD=2.904e-15 AS=2.904e-15 PD=2.2e-07 PS=2.2e-07
MNAx4g4 x4g4x x4n2 0 0 nch W=6.6e-08 L=2.2e-08 rgatemod=0 rbodymod=0 AD=2.904e-15 AS=2.904e-15 PD=2.2e-07 PS=2.2e-07
MPAx5g1 x5n1 p2 vdd vdd pch W=1.32e-07 L=2.2e-08 rgatemod=0 rbodymod=0 AD=5.808e-15 AS=5.808e-15 PD=3.52e-07 PS=3.52e-07
MPBx5g1 x5n1 p3 vdd vdd pch W=1.32e-07 L=2.2e-08 rgatemod=0 rbodymod=0 AD=5.808e-15 AS=5.808e-15 PD=3.52e-07 PS=3.52e-07
MNBx5g1 x5n1 p3 x5g1x 0 nch W=6.6e-08 L=2.2e-08 rgatemod=0 rbodymod=0 AD=2.904e-15 AS=2.904e-15 PD=2.2e-07 PS=2.2e-07
MNAx5g1 x5g1x p2 0 0 nch W=6.6e-08 L=2.2e-08 rgatemod=0 rbodymod=0 AD=2.904e-15 AS=2.904e-15 PD=2.2e-07 PS=2.2e-07
MPAx5g2 x5n2 p2 vdd vdd pch W=1.32e-07 L=2.2e-08 rgatemod=0 rbodymod=0 AD=5.808e-15 AS=5.808e-15 PD=3.52e-07 PS=3.52e-07
MPBx5g2 x5n2 x5n1 vdd vdd pch W=1.32e-07 L=2.2e-08 rgatemod=0 rbodymod=0 AD=5.808e-15 AS=5.808e-15 PD=3.52e-07 PS=3.52e-07
MNBx5g2 x5n2 x5n1 x5g2x 0 nch W=6.6e-08 L=2.2e-08 rgatemod=0 rbodymod=0 AD=2.904e-15 AS=2.904e-15 PD=2.2e-07 PS=2.2e-07
MNAx5g2 x5g2x p2 0 0 nch W=6.6e-08 L=2.2e-08 rgatemod=0 rbodymod=0 AD=2.904e-15 AS=2.904e-15 PD=2.2e-07 PS=2.2e-07
MPAx5g3 x5n3 p3 vdd vdd pch W=1.32e-07 L=2.2e-08 rgatemod=0 rbodymod=0 AD=5.808e-15 AS=5.808e-15 PD=3.52e-07 PS=3.52e-07
MPBx5g3 x5n3 x5n1 vdd vdd pch W=1.32e-07 L=2.2e-08 rgatemod=0 rbodymod=0 AD=5.808e-15 AS=5.808e-15 PD=3.52e-07 PS=3.52e-07
MNBx5g3 x5n3 x5n1 x5g3x 0 nch W=6.6e-08 L=2.2e-08 rgatemod=0 rbodymod=0 AD=2.904e-15 AS=2.904e-15 PD=2.2e-07 PS=2.2e-07
MNAx5g3 x5g3x p3 0 0 nch W=6.6e-08 L=2.2e-08 rgatemod=0 rbodymod=0 AD=2.904e-15 AS=2.904e-15 PD=2.2e-07 PS=2.2e-07
MPAx5g4 q1 x5n2 vdd vdd pch W=1.32e-07 L=2.2e-08 rgatemod=0 rbodymod=0 AD=5.808e-15 AS=5.808e-15 PD=3.52e-07 PS=3.52e-07
MPBx5g4 q1 x5n3 vdd vdd pch W=1.32e-07 L=2.2e-08 rgatemod=0 rbodymod=0 AD=5.808e-15 AS=5.808e-15 PD=3.52e-07 PS=3.52e-07
MNBx5g4 q1 x5n3 x5g4x 0 nch W=6.6e-08 L=2.2e-08 rgatemod=0 rbodymod=0 AD=2.904e-15 AS=2.904e-15 PD=2.2e-07 PS=2.2e-07
MNAx5g4 x5g4x x5n2 0 0 nch W=6.6e-08 L=2.2e-08 rgatemod=0 rbodymod=0 AD=2.904e-15 AS=2.904e-15 PD=2.2e-07 PS=2.2e-07
MPAx6g1 x6n1 q0 vdd vdd pch W=1.32e-07 L=2.2e-08 rgatemod=0 rbodymod=0 AD=5.808e-15 AS=5.808e-15 PD=3.52e-07 PS=3.52e-07
MPBx6g1 x6n1 q1 vdd vdd pch W=1.32e-07 L=2.2e-08 rgatemod=0 rbodymod=0 AD=5.808e-15 AS=5.808e-15 PD=3.52e-07 PS=3.52e-07
MNBx6g1 x6n1 q1 x6g1x 0 nch W=6.6e-08 L=2.2e-08 rgatemod=0 rbodymod=0 AD=2.904e-15 AS=2.904e-15 PD=2.2e-07 PS=2.2e-07
MNAx6g1 x6g1x q0 0 0 nch W=6.6e-08 L=2.2e-08 rgatemod=0 rbodymod=0 AD=2.904e-15 AS=2.904e-15 PD=2.2e-07 PS=2.2e-07
MPAx6g2 x6n2 q0 vdd vdd pch W=1.32e-07 L=2.2e-08 rgatemod=0 rbodymod=0 AD=5.808e-15 AS=5.808e-15 PD=3.52e-07 PS=3.52e-07
MPBx6g2 x6n2 x6n1 vdd vdd pch W=1.32e-07 L=2.2e-08 rgatemod=0 rbodymod=0 AD=5.808e-15 AS=5.808e-15 PD=3.52e-07 PS=3.52e-07
MNBx6g2 x6n2 x6n1 x6g2x 0 nch W=6.6e-08 L=2.2e-08 rgatemod=0 rbodymod=0 AD=2.904e-15 AS=2.904e-15 PD=2.2e-07 PS=2.2e-07
MNAx6g2 x6g2x q0 0 0 nch W=6.6e-08 L=2.2e-08 rgatemod=0 rbodymod=0 AD=2.904e-15 AS=2.904e-15 PD=2.2e-07 PS=2.2e-07
MPAx6g3 x6n3 q1 vdd vdd pch W=1.32e-07 L=2.2e-08 rgatemod=0 rbodymod=0 AD=5.808e-15 AS=5.808e-15 PD=3.52e-07 PS=3.52e-07
MPBx6g3 x6n3 x6n1 vdd vdd pch W=1.32e-07 L=2.2e-08 rgatemod=0 rbodymod=0 AD=5.808e-15 AS=5.808e-15 PD=3.52e-07 PS=3.52e-07
MNBx6g3 x6n3 x6n1 x6g3x 0 nch W=6.6e-08 L=2.2e-08 rgatemod=0 rbodymod=0 AD=2.904e-15 AS=2.904e-15 PD=2.2e-07 PS=2.2e-07
MNAx6g3 x6g3x q1 0 0 nch W=6.6e-08 L=2.2e-08 rgatemod=0 rbodymod=0 AD=2.904e-15 AS=2.904e-15 PD=2.2e-07 PS=2.2e-07
MPAx6g4 out x6n2 vdd vdd pch W=1.32e-07 L=2.2e-08 rgatemod=0 rbodymod=0 AD=5.808e-15 AS=5.808e-15 PD=3.52e-07 PS=3.52e-07
MPBx6g4 out x6n3 vdd vdd pch W=1.32e-07 L=2.2e-08 rgatemod=0 rbodymod=0 AD=5.808e-15 AS=5.808e-15 PD=3.52e-07 PS=3.52e-07
MNBx6g4 out x6n3 x6g4x 0 nch W=6.6e-08 L=2.2e-08 rgatemod=0 rbodymod=0 AD=2.904e-15 AS=2.904e-15 PD=2.2e-07 PS=2.2e-07
MNAx6g4 x6g4x x6n2 0 0 nch W=6.6e-08 L=2.2e-08 rgatemod=0 rbodymod=0 AD=2.904e-15 AS=2.904e-15 PD=2.2e-07 PS=2.2e-07
Vdd vdd 0 0.9003397535
Vi0 i0 0 0
Vi1 i1 0 0
Vi2 i2 0 0
Vi3 i3 0 0
Vi4 i4 0 0
Vi5 i5 0 0
Vi6 i6 0 0
Vi7 i7 0 0
.control
set numdgt=15
op
print v(out) i(vdd) i(vi0) i(vi1) i(vi2) i(vi3) i(vi4) i(vi5) i(vi6) i(vi7)
.endc
.end
